* GRaCEmo ViRa Circuit D - CAN electrical-layer equivalent only
* Not a full SN65HVD230 transistor-level vendor model; no CAN protocol/firmware.
Vcc vcc 0 3.3
* Two simplified dominant/recessive differential drivers
Vtx1 tx1 0 PULSE(0 3.3 1m 10n 10n 1m 2m)
Vtx2 tx2 0 PULSE(0 3.3 1.5m 10n 10n 1m 3m)
Bdrv1 canh1 0 V={if(V(tx1)>1.65,3.5,2.5)}
Bdrv1l canl1 0 V={if(V(tx1)>1.65,1.5,2.5)}
Bdrv2 canh2 0 V={if(V(tx2)>1.65,3.5,2.5)}
Bdrv2l canl2 0 V={if(V(tx2)>1.65,1.5,2.5)}
Rout1h canh1 canh 10
Rout1l canl1 canl 10
Rout2h canh2 canh 10
Rout2l canl2 canl 10
Rterm canh canl 60
RbiasH canh vcc 100k
RbiasL canl 0 100k
.tran 10u 6m
.control
set noaskquit
tran 10u 6m
print v(tx1) v(tx2) v(canh) v(canl) v(canh,canl)
.endc
.end
