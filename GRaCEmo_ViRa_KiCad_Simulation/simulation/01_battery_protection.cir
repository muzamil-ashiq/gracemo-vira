* GRaCEmo ViRa Circuit A - battery input/protection educational equivalent
* Not a fuse-interruption, BMS, or validated TVS model.
.param VBAT=24
Vbat src 0 {VBAT}
* Fuse equivalent: fixed series resistance only; does not open on overcurrent
R_fuse src fused 0.05
* Reverse polarity protection represented by a Schottky diode model
Drev fused prot DPROT
.model DPROT D(Is=2u Rs=0.03 N=1.2 Cjo=100p)
* TVS simplified avalanche clamp, educational only
Dclamp 0 prot DTVS
.model DTVS D(Bv=33 Ibv=1m Rs=0.2 N=1.5)
Cbulk prot 0 470u
Rbleed prot 0 10k
Vsw_ctrl swctrl 0 PULSE(0 5 5m 1u 1u 20m 40m)
Smain prot out swctrl 0 SWMOD
.model SWMOD SW(Ron=0.02 Roff=1e9 Vt=2.5 Vh=0.1)
Cout out 0 100u
Rload out 0 48
.tran 20u 80m
.control
set noaskquit
tran 20u 80m
print v(src) v(prot) v(out) i(Vbat)
.endc
.end
